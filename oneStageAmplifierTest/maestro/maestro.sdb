ADE simulation setup
Run mode: Single Run, Sweeps and Corners
Tests:
  ese516_oneStageAmplifierTest_1: ese516/oneStageAmplifierTest/schematic, simulator spectre
