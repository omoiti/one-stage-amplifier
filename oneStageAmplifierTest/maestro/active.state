ADE simulation setup
Test ese516_oneStageAmplifierTest_1: ese516/oneStageAmplifierTest/schematic, simulator spectre
  Models: /usr/local/cds/ncsu/models/spectre/nom/ami06N.m, /usr/local/cds/ncsu/models/spectre/nom/ami06P.m
  Temperature: 27
  Analysis ac: start=10 stop=200M dec=10
  Signals: /Vout
Run mode: Single Run, Sweeps and Corners
